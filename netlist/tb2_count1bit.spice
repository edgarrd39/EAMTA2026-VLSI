** sch_path: /home/eamtastudent/EAMTA2026-VLSI/verification/testbenches/tb2_count1bit.sch
**.subckt tb2_count1bit
V4 avss1p8 GND DC{vss}
V5 avdd1p8 avss1p8 DC{vdd}
V6 clk_sig avss1p8 PULSE({vdd} 0 0.0 1p 1p {Tclk/4} {Tclk/2}) DC 0 AC 0
x1 avdd1p8 avss1p8 in d clr_in clk_sig sum count1bit
C1 d avss1p8 1p
C2 sum avss1p8 1p
V1 in avss1p8 PULSE({0} {vdd} 85n 1p 1p ) DC 0 AC 0
V2 clr_in avss1p8 PULSE({vdd} {0} 65n 1p 1p ) DC 0 AC 0
**** begin user architecture code

* Circuit Parameters
.param vdd = 1.2
.param vss = 0.0
.param Tclk = 100n
.param Tin = 1000n
.options TEMP = 27.0
* Include Models - IHP SG13G2
.lib cornerMOSlv.lib mos_tt
* OP Parameters & Singals to save
.save all
*Simulations
.control
tran 0.1u 1000n
setplot tran1
plot v(clk_sig) v(sum)+1.2 v(d)+2.4 v(in)+3.6
reset
dc V6 0 1.2 0.01
setplot dc
set filetype = ascii
write dcsweep.raw
.endc
.end

**** end user architecture code
**.ends

* expanding   symbol:  blocks/count1bit/schematic/count1bit.sym # of pins=7
** sym_path: /home/eamtastudent/EAMTA2026-VLSI/design/blocks/count1bit/schematic/count1bit.sym
** sch_path: /home/eamtastudent/EAMTA2026-VLSI/design/blocks/count1bit/schematic/count1bit.sch
.subckt count1bit vdd vss ce q clr clk sout
*.iopin ce
*.iopin clk
*.iopin clr
*.iopin sout
*.iopin q
*.iopin vdd
*.iopin vss
x1 vdd ce sout q vss andgate
x2 vdd q net1 ce vss xor
x3 q net2 net1 vss clk clr vdd dff
* noconn #net2
.ends

* expanding   symbol:  blocks/andgate/schematic/andgate.sym # of pins=5
** sym_path: /home/eamtastudent/EAMTA2026-VLSI/design/blocks/andgate/schematic/andgate.sym
** sch_path: /home/eamtastudent/EAMTA2026-VLSI/design/blocks/andgate/schematic/andgate.sch
.subckt andgate vdd a out b vss
*.iopin a
*.iopin b
*.iopin vss
*.iopin vdd
*.iopin out
x1 a b net1 vss vdd nand
x2 vdd out net1 vss inverter
.ends

* expanding   symbol:  blocks/xorgate/schematic/xor.sym # of pins=5
** sym_path: /home/eamtastudent/EAMTA2026-VLSI/design/blocks/xorgate/schematic/xor.sym
** sch_path: /home/eamtastudent/EAMTA2026-VLSI/design/blocks/xorgate/schematic/xor.sch
.subckt xor vdd a out b vss
*.iopin vss
*.iopin vdd
*.iopin a
*.iopin b
*.iopin out
XM1 net1 bb vdd vdd sg13_lv_pmos w=1.5u l=0.15u ng=1
XM2 out ab net2 vss sg13_lv_nmos w=1.5uu l=0.15u ng=1
XM3 net1 ab vdd vdd sg13_lv_pmos w=1.5u l=0.15u ng=1
XM4 out a net1 vdd sg13_lv_pmos w=1.5u l=0.15u ng=1
XM5 out b net1 vdd sg13_lv_pmos w=1.5u l=0.15u ng=1
XM6 out a net3 vss sg13_lv_nmos w=1.5u l=0.15u ng=1
x1 vdd ab a vss inverter
x2 vdd bb b vss inverter
XM7 net2 bb vss vss sg13_lv_nmos w=1.5u l=0.15u ng=1
XM8 net3 b vss vss sg13_lv_nmos w=1.5u l=0.15u ng=1
.ends

* expanding   symbol:  blocks/dff/schematic/dff.sym # of pins=7
** sym_path: /home/eamtastudent/EAMTA2026-VLSI/design/blocks/dff/schematic/dff.sym
** sch_path: /home/eamtastudent/EAMTA2026-VLSI/design/blocks/dff/schematic/dff.sch
.subckt dff q qb d vss clk clr vdd
*.iopin d
*.iopin clk
*.iopin clr
*.iopin q
*.iopin qb
*.iopin vdd
*.iopin vss
x1 clk vss net1 d vdd clkb transmissiongate
x2 vdd p1 clr net2 vss nor
x3 vdd clkb clk vss inverter
x4 clkb vss net1 net2 vdd clk transmissiongate
x5 clkb vss net3 p1 vdd clk transmissiongate
x6 clk vss qb net3 vdd clkb transmissiongate
x7 vdd clr net3 q vss nor
x8 vdd p1 net1 vss inverter
x9 vdd qb q vss inverter
.ends

* expanding   symbol:  blocks/nandgate/schematic/nand.sym # of pins=5
** sym_path: /home/eamtastudent/EAMTA2026-VLSI/design/blocks/nandgate/schematic/nand.sym
** sch_path: /home/eamtastudent/EAMTA2026-VLSI/design/blocks/nandgate/schematic/nand.sch
.subckt nand a b out vss vdd
*.iopin vdd
*.iopin a
*.iopin vss
*.iopin out
*.iopin b
XM1 out a vdd vdd sg13_lv_pmos w=1.5u l=0.15u ng=1
XM2 out a net1 vss sg13_lv_nmos w=1.5u l=0.15u ng=1
XM3 net1 b vss vss sg13_lv_nmos w=1.5u l=0.15u ng=1
XM4 out b vdd vdd sg13_lv_pmos w=1.5u l=0.15u ng=1
.ends

* expanding   symbol:  blocks/inverter/schematic/inverter.sym # of pins=4
** sym_path: /home/eamtastudent/EAMTA2026-VLSI/design/blocks/inverter/schematic/inverter.sym
** sch_path: /home/eamtastudent/EAMTA2026-VLSI/design/blocks/inverter/schematic/inverter.sch
.subckt inverter vdd out in vss
*.iopin vdd
*.iopin out
*.iopin vss
*.iopin in
XM1 out in vss vss sg13_lv_nmos w=0.75u l=0.15u ng=1
XM2 out in vdd vdd sg13_lv_pmos w=1.5u l=0.15u ng=1
.ends

* expanding   symbol:  blocks/transmissiongate/schematic/transmissiongate.sym # of pins=6
** sym_path: /home/eamtastudent/EAMTA2026-VLSI/design/blocks/transmissiongate/schematic/transmissiongate.sym
** sch_path: /home/eamtastudent/EAMTA2026-VLSI/design/blocks/transmissiongate/schematic/transmissiongate.sch
.subckt transmissiongate clk vss out d vdd clkb
*.iopin out
*.iopin d
*.iopin clkb
*.iopin clk
*.iopin vdd
*.iopin vss
XM1 out clkb d vdd sg13_lv_pmos w=1.5u l=0.15u ng=1
XM0 d clk out vss sg13_lv_nmos w=0.75u l=0.15u ng=1
.ends

* expanding   symbol:  blocks/norgate/schematic/nor.sym # of pins=5
** sym_path: /home/eamtastudent/EAMTA2026-VLSI/design/blocks/norgate/schematic/nor.sym
** sch_path: /home/eamtastudent/EAMTA2026-VLSI/design/blocks/norgate/schematic/nor.sch
.subckt nor vdd a b out vss
*.iopin vdd
*.iopin b
*.iopin vss
*.iopin out
*.iopin a
XM1 net1 b vdd vdd sg13_lv_pmos w=3.0u l=0.15u ng=1
XM2 out b vss vss sg13_lv_nmos w=0.75u l=0.15u ng=1
XM3 out a vss vss sg13_lv_nmos w=0.75u l=0.15u ng=1
XM4 out a net1 vdd sg13_lv_pmos w=3.0u l=0.15u ng=1
.ends

.GLOBAL GND
.end
