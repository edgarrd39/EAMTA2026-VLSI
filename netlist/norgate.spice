** sch_path: /home/mateo/GitRepos/IVAN-EAMTA2026/design/blocks/norgate/schematic/norgate.sch
**.subckt norgate vdd b_in a_in out vss
*.iopin a_in
*.iopin out
*.iopin vss
*.iopin vdd
*.iopin b_in
XM1 net1 b_in vdd vdd sg13_lv_pmos w=3.0u l=0.15u ng=1 m=1
XM2 out a_in vss vss sg13_lv_nmos w=0.75u l=0.15u ng=1 m=1
XM3 out b_in vss vss sg13_lv_nmos w=0.75u l=0.15u ng=1 m=1
XM4 out a_in net1 vdd sg13_lv_pmos w=3.0u l=0.15u ng=1 m=1
**.ends
.end
