** sch_path: /home/eamtastudent/EAMTA2026-VLSI/verification/testbenches/transmissiongate/tb_transmisiongate.sch
**.subckt tb_transmisiongate
C1 vout avss1p8 100f
V4 avss1p8 GND DC{vss}
V6 d avss1p8 PULSE({vdd} 0 0.0 1p 1p {Tffd/4} {Tffd/2}) DC 0 AC 0
x1 clk avss1p8 vout d avdd1p8 net1 transmissiongate
V10 clk avss1p8 PULSE({vdd} 0 0.0 1p 1p {Tclk/4} {Tclk/2}) DC 0 AC 0
x2 avdd1p8 net1 clk avss1p8 inverter
V5 avdd1p8 avss1p8 DC{vdd}
**** begin user architecture code

* Circuit Parameters
.param vdd = 1.2
.param vss = 0.0
.param Tclk = 10n
.param Tffd = 85n
.options TEMP = 27.0
* Include Models - IHP SG13G2
.lib cornerMOSlv.lib mos_tt
* OP Parameters & Singals to save
.save all
*Simulations
.control
tran 0.01u 100n
setplot tran1
plot v(d) v(clk)+1.2 v(vout)+2.4
reset
dc V6 0 1.2 0.01
setplot dc
plot vin vout ylabel vout xlabel vin
set filetype = ascii
write dcsweep.raw
.endc
.end

**** end user architecture code
**.ends

* expanding   symbol:  blocks/transmissiongate/schematic/transmissiongate.sym # of pins=6
** sym_path: /home/eamtastudent/EAMTA2026-VLSI/design/blocks/transmissiongate/schematic/transmissiongate.sym
** sch_path: /home/eamtastudent/EAMTA2026-VLSI/design/blocks/transmissiongate/schematic/transmissiongate.sch
.subckt transmissiongate clk vss out d vdd clkb
*.iopin out
*.iopin d
*.iopin clkb
*.iopin clk
*.iopin vdd
*.iopin vss
XM1 out clkb d vdd sg13_lv_pmos w=1.5u l=0.15u ng=1
XM0 d clk out vss sg13_lv_nmos w=0.75u l=0.15u ng=1
.ends

* expanding   symbol:  blocks/inverter/schematic/inverter.sym # of pins=4
** sym_path: /home/eamtastudent/EAMTA2026-VLSI/design/blocks/inverter/schematic/inverter.sym
** sch_path: /home/eamtastudent/EAMTA2026-VLSI/design/blocks/inverter/schematic/inverter.sch
.subckt inverter vdd out in vss
*.iopin vdd
*.iopin out
*.iopin vss
*.iopin in
XM1 out in vss vss sg13_lv_nmos w=0.75u l=0.15u ng=1
XM2 out in vdd vdd sg13_lv_pmos w=1.5u l=0.15u ng=1
.ends

.GLOBAL GND
.end
