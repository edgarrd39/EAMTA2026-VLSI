** sch_path: /home/eamtastudent/EAMTA2026-VLSI/design/blocks/andgate/schematic/andgate.sch
**.subckt andgate vdd a out b vss
*.iopin a
*.iopin b
*.iopin vss
*.iopin vdd
*.iopin out
x1 a b net1 vss vdd nand
x2 vdd out net1 vss inverter
**.ends

* expanding   symbol:  blocks/nandgate/schematic/nand.sym # of pins=5
** sym_path: /home/eamtastudent/EAMTA2026-VLSI/design/blocks/nandgate/schematic/nand.sym
** sch_path: /home/eamtastudent/EAMTA2026-VLSI/design/blocks/nandgate/schematic/nand.sch
.subckt nand a b out vss vdd
*.iopin vdd
*.iopin a
*.iopin vss
*.iopin out
*.iopin b
XM1 out a vdd vdd sg13_lv_pmos w=0.15u l=0.13u ng=1
XM2 out a net1 vss sg13_lv_nmos w=0.15u l=0.13u ng=1
XM3 net1 b vss vss sg13_lv_nmos w=0.15u l=0.13u ng=1
XM4 out b vdd vdd sg13_lv_pmos w=0.15u l=0.13u ng=1
.ends

* expanding   symbol:  blocks/inverter/schematic/inverter.sym # of pins=4
** sym_path: /home/eamtastudent/EAMTA2026-VLSI/design/blocks/inverter/schematic/inverter.sym
** sch_path: /home/eamtastudent/EAMTA2026-VLSI/design/blocks/inverter/schematic/inverter.sch
.subckt inverter vdd out in vss
*.iopin vdd
*.iopin out
*.iopin vss
*.iopin in
XM1 out in vss vss sg13_lv_nmos w=0.75u l=0.15u ng=1
XM2 out in vdd vdd sg13_lv_pmos w=1.5u l=0.15u ng=1
.ends

.end
