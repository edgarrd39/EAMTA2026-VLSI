** sch_path: /home/mateo/GitRepos/IVAN-EAMTA2026/design/blocks/andgate/schematic/andgate.sch
**.subckt andgate vdd a_in out b_in vss
*.iopin b_in
*.iopin a_in
*.iopin out
*.iopin vdd
*.iopin vss
XM0 net2 a_in vdd vdd sg13_lv_pmos w=1.5u l=0.15u ng=1 m=1
XM1 net2 b_in vdd vdd sg13_lv_pmos w=1.5u l=0.15u ng=1 m=1
XM2 net2 a_in net1 vss sg13_lv_nmos w=1.5u l=0.15u ng=1 m=1
XM3 net1 b_in vss vss sg13_lv_nmos w=1.5u l=0.15u ng=1 m=1
XM4 out net2 vdd vdd sg13_lv_pmos w=1.5u l=0.15u ng=1 m=1
XM5 out net2 vss vss sg13_lv_nmos w=0.75u l=0.15u ng=1 m=1
**.ends
.end
