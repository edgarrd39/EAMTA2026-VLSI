** sch_path: /home/eamtastudent/EAMTA2026-VLSI/verification/testbenches/counter4b_ed/tb_counter4b.sch
**.subckt tb_counter4b
x1 avdd1p8 avss1p8 q1 avdd1p8 avdd1p8 clk q2 q3 q4 counter4b
V4 avss1p8 GND DC{vss}
V10 clk avss1p8 PULSE({vdd} 0 0.0 1p 1p {Tclk/4} {Tclk/2}) DC 0 AC 0
V5 avdd1p8 avss1p8 DC{vdd}
C1 q1 avss1p8 100f
C2 q2 avss1p8 100f
C3 q3 avss1p8 100f
C4 q4 avss1p8 100f
**** begin user architecture code

* Circuit Parameters
.param vdd = 1.2
.param vss = 0.0
.param Tclk = 10n
.param Tffd = 85n
.param Tclear = 165n
.options TEMP = 27.0
* Include Models - IHP SG13G2
.lib cornerMOSlv.lib mos_tt
* OP Parameters & Singals to save
.save all
*Simulations
.control
tran 0.01u 200n
setplot tran1
plot v(clk) v(q1)+2.4 v(q2)+3.6 v(q3)+4.8 v(q4)+6.0
reset
dc V6 0 1.2 0.01
setplot dc
plot vin vout ylabel vout xlabel vin
set filetype = ascii
write dcsweep.raw
.endc
.end

**** end user architecture code
**.ends

* expanding   symbol:  blocks/counter4b/schematic/counter4b.sym # of pins=9
** sym_path: /home/eamtastudent/EAMTA2026-VLSI/design/blocks/counter4b/schematic/counter4b.sym
** sch_path: /home/eamtastudent/EAMTA2026-VLSI/design/blocks/counter4b/schematic/counter4b.sch
.subckt counter4b vdd vss q1 ce clr clk q2 q3 q4
*.iopin ce
*.iopin q1
*.iopin q2
*.iopin q3
*.iopin q4
*.iopin clk
*.iopin clr
*.iopin vss
*.iopin vdd
x1 vdd ce net3 q1 vss andgate
x2 vdd q1 net1 ce vss xor
x3 q1 net8 net1 vss clk clr vdd dff
x4 vdd net3 net4 q2 vss andgate
x5 vdd q2 net2 net3 vss xor
x6 q2 net9 net2 vss clk clr vdd dff
x7 vdd net4 net7 q3 vss andgate
x8 vdd q3 net5 net4 vss xor
x9 q3 net10 net5 vss clk clr vdd dff
x11 vdd q4 net6 net7 vss xor
x12 q4 net11 net6 vss clk clr vdd dff
.ends

* expanding   symbol:  blocks/andgate/schematic/andgate.sym # of pins=5
** sym_path: /home/eamtastudent/EAMTA2026-VLSI/design/blocks/andgate/schematic/andgate.sym
** sch_path: /home/eamtastudent/EAMTA2026-VLSI/design/blocks/andgate/schematic/andgate.sch
.subckt andgate vdd a out b vss
*.iopin a
*.iopin b
*.iopin vss
*.iopin vdd
*.iopin out
x1 a b net1 vss vdd nand
x2 vdd out net1 vss inverter
.ends

* expanding   symbol:  blocks/xorgate/schematic/xor.sym # of pins=5
** sym_path: /home/eamtastudent/EAMTA2026-VLSI/design/blocks/xorgate/schematic/xor.sym
** sch_path: /home/eamtastudent/EAMTA2026-VLSI/design/blocks/xorgate/schematic/xor.sch
.subckt xor vdd a out b vss
*.iopin vss
*.iopin vdd
*.iopin a
*.iopin b
*.iopin out
XM1 net1 bb vdd vdd sg13_lv_pmos w=1.5u l=0.15u ng=1
XM2 out ab net2 vss sg13_lv_nmos w=1.5uu l=0.15u ng=1
XM3 net1 ab vdd vdd sg13_lv_pmos w=1.5u l=0.15u ng=1
XM4 out a net1 vdd sg13_lv_pmos w=1.5u l=0.15u ng=1
XM5 out b net1 vdd sg13_lv_pmos w=1.5u l=0.15u ng=1
XM6 out a net3 vss sg13_lv_nmos w=1.5u l=0.15u ng=1
x1 vdd ab a vss inverter
x2 vdd bb b vss inverter
XM7 net2 bb vss vss sg13_lv_nmos w=1.5u l=0.15u ng=1
XM8 net3 b vss vss sg13_lv_nmos w=1.5u l=0.15u ng=1
.ends

* expanding   symbol:  blocks/dff/schematic/dff.sym # of pins=7
** sym_path: /home/eamtastudent/EAMTA2026-VLSI/design/blocks/dff/schematic/dff.sym
** sch_path: /home/eamtastudent/EAMTA2026-VLSI/design/blocks/dff/schematic/dff.sch
.subckt dff q qb d vss clk clr vdd
*.iopin d
*.iopin clk
*.iopin clr
*.iopin q
*.iopin qb
*.iopin vdd
*.iopin vss
x1 clk vss net1 d vdd clkb transmissiongate
x2 vdd clr net2 net3 vss nor
x3 vdd clkb clk vss inverter
x4 clk vss net3 net1 vdd clkb transmissiongate
x5 clk vss net4 net2 vdd clkb transmissiongate
x6 clk vss qb net4 vdd clkb transmissiongate
x7 vdd net4 clr q vss nor
x8 vss net2 net1 vss inverter
x9 vdd qb q vss inverter
.ends

* expanding   symbol:  blocks/nandgate/schematic/nand.sym # of pins=5
** sym_path: /home/eamtastudent/EAMTA2026-VLSI/design/blocks/nandgate/schematic/nand.sym
** sch_path: /home/eamtastudent/EAMTA2026-VLSI/design/blocks/nandgate/schematic/nand.sch
.subckt nand a b out vss vdd
*.iopin vdd
*.iopin a
*.iopin vss
*.iopin out
*.iopin b
XM1 out a vdd vdd sg13_lv_pmos w=1.5u l=0.15u ng=1
XM2 out a net1 vss sg13_lv_nmos w=1.5u l=0.15u ng=1
XM3 net1 b vss vss sg13_lv_nmos w=1.5u l=0.15u ng=1
XM4 out b vdd vdd sg13_lv_pmos w=1.5u l=0.15u ng=1
.ends

* expanding   symbol:  blocks/inverter/schematic/inverter.sym # of pins=4
** sym_path: /home/eamtastudent/EAMTA2026-VLSI/design/blocks/inverter/schematic/inverter.sym
** sch_path: /home/eamtastudent/EAMTA2026-VLSI/design/blocks/inverter/schematic/inverter.sch
.subckt inverter vdd out in vss
*.iopin vdd
*.iopin out
*.iopin vss
*.iopin in
XM1 out in vss vss sg13_lv_nmos w=0.75u l=0.15u ng=1
XM2 out in vdd vdd sg13_lv_pmos w=1.5u l=0.15u ng=1
.ends

* expanding   symbol:  blocks/transmissiongate/schematic/transmissiongate.sym # of pins=6
** sym_path: /home/eamtastudent/EAMTA2026-VLSI/design/blocks/transmissiongate/schematic/transmissiongate.sym
** sch_path: /home/eamtastudent/EAMTA2026-VLSI/design/blocks/transmissiongate/schematic/transmissiongate.sch
.subckt transmissiongate clk vss out d vdd clkb
*.iopin out
*.iopin d
*.iopin clkb
*.iopin clk
*.iopin vdd
*.iopin vss
XM1 out clkb d vdd sg13_lv_pmos w=1.5u l=0.15u ng=1
XM0 d clk out vss sg13_lv_nmos w=0.75u l=0.15u ng=1
.ends

* expanding   symbol:  blocks/norgate/schematic/nor.sym # of pins=5
** sym_path: /home/eamtastudent/EAMTA2026-VLSI/design/blocks/norgate/schematic/nor.sym
** sch_path: /home/eamtastudent/EAMTA2026-VLSI/design/blocks/norgate/schematic/nor.sch
.subckt nor vdd a b out vss
*.iopin vdd
*.iopin a
*.iopin vss
*.iopin out
*.iopin b
XM1 net1 a vdd vdd sg13_lv_pmos w=3.0u l=0.15u ng=1
XM2 out b vss vss sg13_lv_nmos w=0.75u l=0.15u ng=1
XM3 out a vss vss sg13_lv_nmos w=0.75u l=0.15u ng=1
XM4 out b net1 vdd sg13_lv_pmos w=3.0u l=0.15u ng=1
.ends

.GLOBAL GND
.end
