** sch_path: /home/mateo/GitRepos/IVAN-EAMTA2026/design/blocks/inverter/schematic/inverter.sch
**.subckt inverter vdd out in vss
*.iopin vdd
*.iopin out
*.iopin vss
*.iopin in
XM1 out in vss vss sg13_lv_nmos w=0.39u l=0.13u ng=1 m=1
XM2 out in vdd vdd sg13_lv_pmos w=1.17u l=0.13u ng=1 m=1
**.ends
.end
