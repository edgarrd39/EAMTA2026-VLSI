** sch_path: /home/eamtastudent/EAMTA2026-VLSI/design/blocks/inverter/schematic/inverter.sch
**.subckt inverter vdd out in vss
*.iopin vdd
*.iopin out
*.iopin vss
*.iopin in
XM1 out in vss vss sg13_lv_nmos w=0.75u l=0.15u ng=1
XM2 out in vdd vdd sg13_lv_pmos w=1.5u l=0.15u ng=1
**.ends
.end
