** sch_path: /home/eamtastudent/EAMTA2026-VLSI/design/blocks/inverter/inverter.sch
**.subckt inverter
XM1 net1 net2 net3 net4 sg13_lv_pmos w=0.15u l=0.13u ng=1
**.ends
.end
