** sch_path: /home/eamtastudent/EAMTA2026-VLSI/design/blocks/transmissiongate/schematic/transmissiongate.sch
.subckt transmissiongate clk vss out d vdd clkb
*.PININFO out:B d:B clkb:B clk:B vdd:B vss:B
M1 out clkb d vdd sg13_lv_pmos w=1.5u l=0.15u ng=1
M0 d clk out vss sg13_lv_nmos w=0.75u l=0.15u ng=1
.ends
