** sch_path: /home/eamtastudent/EAMTA2026-VLSI/design/blocks/dff/schematic/dff.sch
**.subckt dff q qb d vss clk clr vdd
*.iopin d
*.iopin clk
*.iopin clr
*.iopin q
*.iopin qb
*.iopin vdd
*.iopin vss
x1 clk vss net1 d vdd clkb transmissiongate
x2 vdd p1 clr net2 vss nor
x3 vdd clkb clk vss inverter
x4 clkb vss net1 net2 vdd clk transmissiongate
x5 clkb vss net3 p1 vdd clk transmissiongate
x6 clk vss qb net3 vdd clkb transmissiongate
x7 vdd clr net3 q vss nor
x8 vdd p1 net1 vss inverter
x9 vdd qb q vss inverter
**.ends

* expanding   symbol:  blocks/transmissiongate/schematic/transmissiongate.sym # of pins=6
** sym_path: /home/eamtastudent/EAMTA2026-VLSI/design/blocks/transmissiongate/schematic/transmissiongate.sym
** sch_path: /home/eamtastudent/EAMTA2026-VLSI/design/blocks/transmissiongate/schematic/transmissiongate.sch
.subckt transmissiongate clk vss out d vdd clkb
*.iopin out
*.iopin d
*.iopin clkb
*.iopin clk
*.iopin vdd
*.iopin vss
XM1 out clkb d vdd sg13_lv_pmos w=1.5u l=0.15u ng=1
XM0 d clk out vss sg13_lv_nmos w=0.75u l=0.15u ng=1
.ends

* expanding   symbol:  blocks/norgate/schematic/nor.sym # of pins=5
** sym_path: /home/eamtastudent/EAMTA2026-VLSI/design/blocks/norgate/schematic/nor.sym
** sch_path: /home/eamtastudent/EAMTA2026-VLSI/design/blocks/norgate/schematic/nor.sch
.subckt nor vdd a b out vss
*.iopin vdd
*.iopin b
*.iopin vss
*.iopin out
*.iopin a
XM1 net1 b vdd vdd sg13_lv_pmos w=3.0u l=0.15u ng=1
XM2 out b vss vss sg13_lv_nmos w=0.75u l=0.15u ng=1
XM3 out a vss vss sg13_lv_nmos w=0.75u l=0.15u ng=1
XM4 out a net1 vdd sg13_lv_pmos w=3.0u l=0.15u ng=1
.ends

* expanding   symbol:  blocks/inverter/schematic/inverter.sym # of pins=4
** sym_path: /home/eamtastudent/EAMTA2026-VLSI/design/blocks/inverter/schematic/inverter.sym
** sch_path: /home/eamtastudent/EAMTA2026-VLSI/design/blocks/inverter/schematic/inverter.sch
.subckt inverter vdd out in vss
*.iopin vdd
*.iopin out
*.iopin vss
*.iopin in
XM1 out in vss vss sg13_lv_nmos w=0.75u l=0.15u ng=1
XM2 out in vdd vdd sg13_lv_pmos w=1.5u l=0.15u ng=1
.ends

.end
