** sch_path: /home/mateo/GitRepos/IVAN-EAMTA2026/verification/testbenches/count4bits/tb_count4bits.sch
**.subckt tb_count4bits
x1 avdd1p8 avss1p8 avdd1p8 0b clk_sig avss1p8 1b 2b 3b count4bits
V4 avss1p8 GND DC{vss}
V5 avdd1p8 avss1p8 DC{vdd}
V6 clk_sig avss1p8 PULSE({vdd} 0 0.0 1p 1p {Tclk/4} {Tclk/2}) DC 0 AC 0
**** begin user architecture code

* Circuit Parameters
.param vdd = 1.2
.param vss = 0.0
.param Tclk = 10n
.options TEMP = 27.0
* Include Models - IHP SG13G2
.lib cornerMOSlv.lib mos_tt
* OP Parameters & Singals to save
.save all
*Simulations
.control
tran 0.01u 100n
setplot tran1
plot v(clk_sig) v(0b)+1.2 v(1b)+2.4 v(2b)+3.6 v(3b)+4.8
reset
dc V6 0 1.2 0.01
setplot dc
set filetype = ascii
write dcsweep.raw
.endc
.end

**** end user architecture code
**.ends

* expanding   symbol:  top/schematic/count4bits.sym # of pins=9
** sym_path: /home/mateo/GitRepos/IVAN-EAMTA2026/design/top/schematic/count4bits.sym
** sch_path: /home/mateo/GitRepos/IVAN-EAMTA2026/design/top/schematic/count4bits.sch
.subckt count4bits vdd vss CE 00 CLK CLR 01 10 11
*.iopin CE
*.iopin vdd
*.iopin vss
*.iopin CLK
*.iopin 00
*.iopin 01
*.iopin CLR
*.iopin 10
*.iopin 11
x1 vdd 00 CLK CE vss CLR net1 count1bit
x2 vdd 01 CLK net1 vss CLR net2 count1bit
x3 vdd 10 CLK net2 vss CLR net3 count1bit
x4 vdd 11 CLK net3 vss CLR net4 count1bit
.ends

* expanding   symbol:  blocks/count1bit/schematic/count1bit.sym # of pins=7
** sym_path: /home/mateo/GitRepos/IVAN-EAMTA2026/design/blocks/count1bit/schematic/count1bit.sym
** sch_path: /home/mateo/GitRepos/IVAN-EAMTA2026/design/blocks/count1bit/schematic/count1bit.sch
.subckt count1bit vdd Dn CLK CE vss CLR Sout
*.iopin Dn
*.iopin CLK
*.iopin CLR
*.iopin Sout
*.iopin vss
*.iopin CE
*.iopin vdd
x1 net1 Dn CLR net2 vdd CLK vss dff
x2 vdd net1 vss Dn CE xorgate
x3 vdd CE Sout Dn vss andgate
.ends

* expanding   symbol:  blocks/dff/schematic/dff.sym # of pins=7
** sym_path: /home/mateo/GitRepos/IVAN-EAMTA2026/design/blocks/dff/schematic/dff.sym
** sch_path: /home/mateo/GitRepos/IVAN-EAMTA2026/design/blocks/dff/schematic/dff.sch
.subckt dff D Q CLR Qb vdd CLK vss
*.iopin D
*.iopin Q
*.iopin Qb
*.iopin CLK
*.iopin CLR
*.iopin vdd
*.iopin vss
x1 clk_neg net1 D vdd vss clk_pos transmissiongate
x2 clk_pos net4 net2 vdd vss clk_neg transmissiongate
x3 clk_pos net1 net3 vdd vss clk_neg transmissiongate
x4 clk_neg net4 Qb vdd vss clk_pos transmissiongate
x5 vdd CLR net2 net3 vss norgate
x6 vdd CLR net4 Q vss norgate
x7 vdd clk_neg CLK vss inverter
x8 vdd net2 net1 vss inverter
x9 vdd Qb Q vss inverter
x10 vdd clk_pos clk_neg vss inverter
.ends

* expanding   symbol:  blocks/xorgate/schematic/xorgate.sym # of pins=5
** sym_path: /home/mateo/GitRepos/IVAN-EAMTA2026/design/blocks/xorgate/schematic/xorgate.sym
** sch_path: /home/mateo/GitRepos/IVAN-EAMTA2026/design/blocks/xorgate/schematic/xorgate.sch
.subckt xorgate vdd out vss a_in b_in
*.iopin out
*.iopin vdd
*.iopin vss
*.iopin a_in
*.iopin b_in
XM0 net3 b_bis vdd vdd sg13_lv_pmos w=1.5u l=0.15u ng=1 m=1
XM1 net3 a_bis vdd vdd sg13_lv_pmos w=1.5u l=0.15u ng=1 m=1
XM2 out a_in net3 vdd sg13_lv_pmos w=1.5u l=0.15u ng=1 m=1
XM3 out b_in net3 vdd sg13_lv_pmos w=1.5u l=0.15u ng=1 m=1
XM4 out a_bis net1 vss sg13_lv_nmos w=1.5u l=0.15u ng=1 m=1
XM5 out a_in net2 vss sg13_lv_nmos w=1.5u l=0.15u ng=1 m=1
XM6 net1 b_bis vss vss sg13_lv_nmos w=1.5u l=0.15u ng=1 m=1
XM7 net2 b_in vss vss sg13_lv_nmos w=1.5u l=0.15u ng=1 m=1
XM8 a_bis a_in vdd vdd sg13_lv_pmos w=1.5u l=0.15u ng=1 m=1
XM9 a_bis a_in vss vss sg13_lv_nmos w=0.75u l=0.15u ng=1 m=1
XM10 b_bis b_in vdd vdd sg13_lv_pmos w=1.5u l=0.15u ng=1 m=1
XM11 b_bis b_in vss vss sg13_lv_nmos w=0.75u l=0.15u ng=1 m=1
.ends

* expanding   symbol:  blocks/andgate/schematic/andgate.sym # of pins=5
** sym_path: /home/mateo/GitRepos/IVAN-EAMTA2026/design/blocks/andgate/schematic/andgate.sym
** sch_path: /home/mateo/GitRepos/IVAN-EAMTA2026/design/blocks/andgate/schematic/andgate.sch
.subckt andgate vdd a_in out b_in vss
*.iopin b_in
*.iopin a_in
*.iopin out
*.iopin vdd
*.iopin vss
XM0 net2 a_in vdd vdd sg13_lv_pmos w=1.5u l=0.15u ng=1 m=1
XM1 net2 b_in vdd vdd sg13_lv_pmos w=1.5u l=0.15u ng=1 m=1
XM2 net2 a_in net1 vss sg13_lv_nmos w=1.5u l=0.15u ng=1 m=1
XM3 net1 b_in vss vss sg13_lv_nmos w=1.5u l=0.15u ng=1 m=1
XM4 out net2 vdd vdd sg13_lv_pmos w=1.5u l=0.15u ng=1 m=1
XM5 out net2 vss vss sg13_lv_nmos w=0.75u l=0.15u ng=1 m=1
.ends

* expanding   symbol:  blocks/transmissiongate/schematic/transmissiongate.sym # of pins=6
** sym_path: /home/mateo/GitRepos/IVAN-EAMTA2026/design/blocks/transmissiongate/schematic/transmissiongate.sym
** sch_path: /home/mateo/GitRepos/IVAN-EAMTA2026/design/blocks/transmissiongate/schematic/transmissiongate.sch
.subckt transmissiongate a_neg out in vdd vss a_pos
*.iopin vdd
*.iopin vss
*.iopin out
*.iopin in
*.iopin a_neg
*.iopin a_pos
XM0 in a_neg out vdd sg13_lv_pmos w=1.5u l=0.15u ng=1 m=1
XM1 out a_pos in vss sg13_lv_nmos w=0.75u l=0.15u ng=1 m=1
.ends

* expanding   symbol:  blocks/norgate/schematic/norgate.sym # of pins=5
** sym_path: /home/mateo/GitRepos/IVAN-EAMTA2026/design/blocks/norgate/schematic/norgate.sym
** sch_path: /home/mateo/GitRepos/IVAN-EAMTA2026/design/blocks/norgate/schematic/norgate.sch
.subckt norgate vdd b_in a_in out vss
*.iopin a_in
*.iopin out
*.iopin vss
*.iopin vdd
*.iopin b_in
XM1 net1 b_in vdd vdd sg13_lv_pmos w=3.0u l=0.15u ng=1 m=1
XM2 out a_in vss vss sg13_lv_nmos w=0.75u l=0.15u ng=1 m=1
XM3 out b_in vss vss sg13_lv_nmos w=0.75u l=0.15u ng=1 m=1
XM4 out a_in net1 vdd sg13_lv_pmos w=3.0u l=0.15u ng=1 m=1
.ends

* expanding   symbol:  blocks/inverter/schematic/inverter.sym # of pins=4
** sym_path: /home/mateo/GitRepos/IVAN-EAMTA2026/design/blocks/inverter/schematic/inverter.sym
** sch_path: /home/mateo/GitRepos/IVAN-EAMTA2026/design/blocks/inverter/schematic/inverter.sch
.subckt inverter vdd out in vss
*.iopin vdd
*.iopin out
*.iopin vss
*.iopin in
XM1 out in vss vss sg13_lv_nmos w=0.75u l=0.15u ng=1 m=1
XM2 out in vdd vdd sg13_lv_pmos w=1.5u l=0.15u ng=1 m=1
.ends

.GLOBAL GND
.end
