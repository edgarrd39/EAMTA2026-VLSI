* NGSPICE netlist for norgate - IHP SG13G2 PDK
* Generated from norgate.sch
* Implements NOR gate

.subckt norgate vdd a_in b_in vss out
XM1 out b_in vdd vdd sg13_lv_pmos w=4.0u l=0.13u ng=1 m=1
XM4 out a_in vdd vdd sg13_lv_pmos w=4.0u l=0.13u ng=1 m=1
XM2 out a_in vss vss sg13_lv_nmos w=1.0u l=0.13u ng=1 m=1
XM3 out b_in vss vss sg13_lv_nmos w=1.0u l=0.13u ng=1 m=1
.ends norgate
