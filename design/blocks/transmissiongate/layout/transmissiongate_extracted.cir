* Extracted by KLayout with SG13G2 LVS runset on : 13/03/2026 15:55

.SUBCKT transmissiongate
M$1 \$2 \$4 \$3 \$1 sg13_lv_nmos L=0.15u W=0.75u AS=0.255p AD=0.255p PS=2.18u
+ PD=2.18u
M$2 \$2 \$5 \$3 \$6 sg13_lv_pmos L=0.15u W=1.5u AS=0.51p AD=0.51p PS=3.68u
+ PD=3.68u
.ENDS transmissiongate
