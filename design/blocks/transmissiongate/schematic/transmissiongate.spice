* NGSPICE netlist for transmissiongate - IHP SG13G2 PDK
* Generated from transmissiongate.sch

.subckt transmissiongate vdd vss in out a_neg a_pos
XM0 out a_neg in vdd sg13_lv_pmos w=2.0u l=0.13u ng=1 m=1
XM1 in a_pos out vss sg13_lv_nmos w=1.0u l=0.13u ng=1 m=1
.ends transmissiongate
