* Extracted by KLayout with SG13G2 LVS runset on : 14/03/2026 05:50

.SUBCKT xor
M$1 \$1 \$12 \$6 \$1 sg13_lv_nmos L=0.15u W=0.75u AS=0.255p AD=0.255p PS=2.18u
+ PD=2.18u
M$2 \$1 \$13 \$5 \$1 sg13_lv_nmos L=0.15u W=0.75u AS=0.255p AD=0.255p PS=2.18u
+ PD=2.18u
M$3 \$1 \$5 \$2 \$1 sg13_lv_nmos L=0.15u W=1.5u AS=0.51p AD=0.285p PS=3.68u
+ PD=1.88u
M$4 \$2 \$6 \$3 \$1 sg13_lv_nmos L=0.15u W=1.5u AS=0.285p AD=0.285p PS=1.88u
+ PD=1.88u
M$5 \$3 \$12 \$4 \$1 sg13_lv_nmos L=0.15u W=1.5u AS=0.285p AD=0.285p PS=1.88u
+ PD=1.88u
M$6 \$4 \$13 \$1 \$1 sg13_lv_nmos L=0.15u W=1.5u AS=0.285p AD=0.51p PS=1.88u
+ PD=3.68u
M$7 \$15 \$12 \$6 \$15 sg13_lv_pmos L=0.15u W=1.5u AS=0.51p AD=0.51p PS=3.68u
+ PD=3.68u
M$8 \$15 \$13 \$5 \$15 sg13_lv_pmos L=0.15u W=1.5u AS=0.51p AD=0.51p PS=3.68u
+ PD=3.68u
M$9 \$15 \$5 \$16 \$15 sg13_lv_pmos L=0.15u W=1.5u AS=0.51p AD=0.285p PS=3.68u
+ PD=1.88u
M$10 \$16 \$13 \$3 \$15 sg13_lv_pmos L=0.15u W=1.5u AS=0.285p AD=0.285p
+ PS=1.88u PD=1.88u
M$11 \$3 \$12 \$16 \$15 sg13_lv_pmos L=0.15u W=1.5u AS=0.285p AD=0.285p
+ PS=1.88u PD=1.88u
M$12 \$16 \$6 \$15 \$15 sg13_lv_pmos L=0.15u W=1.5u AS=0.285p AD=0.51p PS=1.88u
+ PD=3.68u
.ENDS xor
