* Extracted by KLayout with SG13G2 LVS runset on : 13/03/2026 18:53

.SUBCKT xor
M$1 \$1 \$1 \$10 \$1 sg13_lv_nmos L=0.15u W=0.75u AS=0.255p AD=0.255p PS=2.18u
+ PD=2.18u
M$2 \$1 \$1 \$3 \$1 sg13_lv_nmos L=0.15u W=0.75u AS=0.255p AD=0.255p PS=2.18u
+ PD=2.18u
M$3 \$1 \$3 \$2 \$1 sg13_lv_nmos L=0.15u W=1.5u AS=0.51p AD=0.285p PS=3.68u
+ PD=1.88u
M$4 \$2 \$10 \$1 \$1 sg13_lv_nmos L=0.15u W=1.5u AS=0.285p AD=0.28495p PS=1.88u
+ PD=1.88u
M$5 \$1 \$1 \$1 \$1 sg13_lv_nmos L=0.148289473684u W=3.04u AS=0.56975p
+ AD=0.7945p PS=3.76u PD=5.56u
M$7 \$11 \$3 \$12 \$11 sg13_lv_pmos L=0.15u W=1.5u AS=0.51p AD=0.285p PS=3.68u
+ PD=1.88u
M$8 \$12 \$1 \$1 \$11 sg13_lv_pmos L=0.15u W=3u AS=0.57p AD=0.57p PS=3.76u
+ PD=3.76u
M$10 \$12 \$10 \$11 \$11 sg13_lv_pmos L=0.15u W=1.5u AS=0.285p AD=0.51p
+ PS=1.88u PD=3.68u
M$11 \$11 \$1 \$10 \$11 sg13_lv_pmos L=0.15u W=1.5u AS=0.51p AD=0.51p PS=3.68u
+ PD=3.68u
M$12 \$11 \$1 \$3 \$11 sg13_lv_pmos L=0.15u W=1.5u AS=0.51p AD=0.51p PS=3.68u
+ PD=3.68u
.ENDS xor
