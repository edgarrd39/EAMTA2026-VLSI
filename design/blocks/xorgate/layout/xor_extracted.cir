* Extracted by KLayout with SG13G2 LVS runset on : 21/03/2026 07:09

.SUBCKT xor
M$1 \$14 \$22 \$1 \$1 sg13_lv_nmos L=0.15u W=0.75u AS=0.255p AD=0.255p PS=2.18u
+ PD=2.18u
M$2 \$1 \$2 \$6 \$1 sg13_lv_nmos L=0.15u W=0.75u AS=0.255p AD=0.255p PS=2.18u
+ PD=2.18u
M$3 \$1 \$6 \$3 \$1 sg13_lv_nmos L=0.15u W=1.5u AS=0.51p AD=0.285p PS=3.68u
+ PD=1.88u
M$4 \$3 \$14 \$4 \$1 sg13_lv_nmos L=0.15u W=1.5u AS=0.285p AD=0.285p PS=1.88u
+ PD=1.88u
M$5 \$4 \$22 \$5 \$1 sg13_lv_nmos L=0.15u W=1.5u AS=0.285p AD=0.285p PS=1.88u
+ PD=1.88u
M$6 \$5 \$2 \$1 \$1 sg13_lv_nmos L=0.15u W=1.5u AS=0.285p AD=0.51p PS=1.88u
+ PD=3.68u
M$7 \$15 \$6 \$13 \$15 sg13_lv_pmos L=0.15u W=1.5u AS=0.51p AD=0.285p PS=3.68u
+ PD=1.88u
M$8 \$13 \$2 \$4 \$15 sg13_lv_pmos L=0.15u W=1.5u AS=0.285p AD=0.285p PS=1.88u
+ PD=1.88u
M$9 \$4 \$22 \$13 \$15 sg13_lv_pmos L=0.15u W=1.5u AS=0.285p AD=0.285p PS=1.88u
+ PD=1.88u
M$10 \$13 \$14 \$15 \$15 sg13_lv_pmos L=0.15u W=1.5u AS=0.285p AD=0.51p
+ PS=1.88u PD=3.68u
M$11 \$14 \$22 \$15 \$15 sg13_lv_pmos L=0.15u W=1.5u AS=0.51p AD=0.51p PS=3.68u
+ PD=3.68u
M$12 \$15 \$2 \$6 \$15 sg13_lv_pmos L=0.15u W=1.5u AS=0.51p AD=0.51p PS=3.68u
+ PD=3.68u
.ENDS xor
