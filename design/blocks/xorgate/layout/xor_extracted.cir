* Extracted by KLayout with SG13G2 LVS runset on : 23/03/2026 03:06

.SUBCKT xor vss out vdd
M$1 vss \$2 \$3 vss sg13_lv_nmos L=0.15u W=0.75u AS=0.255p AD=0.255p PS=2.18u
+ PD=2.18u
M$2 \$9 \$16 vss vss sg13_lv_nmos L=0.15u W=0.75u AS=0.255p AD=0.255p PS=2.18u
+ PD=2.18u
M$3 vss \$3 \$4 vss sg13_lv_nmos L=0.15u W=1.5u AS=0.51p AD=0.285p PS=3.68u
+ PD=1.88u
M$4 \$4 \$9 out vss sg13_lv_nmos L=0.15u W=1.5u AS=0.285p AD=0.285p PS=1.88u
+ PD=1.88u
M$5 out \$16 \$6 vss sg13_lv_nmos L=0.15u W=1.5u AS=0.285p AD=0.285p PS=1.88u
+ PD=1.88u
M$6 \$6 \$2 vss vss sg13_lv_nmos L=0.15u W=1.5u AS=0.285p AD=0.51p PS=1.88u
+ PD=3.68u
M$7 vdd \$3 \$15 vdd sg13_lv_pmos L=0.15u W=1.5u AS=0.51p AD=0.285p PS=3.68u
+ PD=1.88u
M$8 \$15 \$2 out vdd sg13_lv_pmos L=0.15u W=1.5u AS=0.285p AD=0.285p PS=1.88u
+ PD=1.88u
M$9 out \$16 \$15 vdd sg13_lv_pmos L=0.15u W=1.5u AS=0.285p AD=0.285p PS=1.88u
+ PD=1.88u
M$10 \$15 \$9 vdd vdd sg13_lv_pmos L=0.15u W=1.5u AS=0.285p AD=0.51p PS=1.88u
+ PD=3.68u
M$11 vdd \$2 \$3 vdd sg13_lv_pmos L=0.15u W=1.5u AS=0.51p AD=0.51p PS=3.68u
+ PD=3.68u
M$12 \$9 \$16 vdd vdd sg13_lv_pmos L=0.15u W=1.5u AS=0.51p AD=0.51p PS=3.68u
+ PD=3.68u
.ENDS xor
