* NGSPICE netlist for xorgate - IHP SG13G2 PDK
* Generated from xorgate.sch

.subckt xorgate vdd vss a_in b_in out
* Complementary stage
XM0 a_bis a_in vdd vdd sg13_lv_pmos w=1.5u l=0.15u ng=1 m=1
XM4 a_bis a_in vss vss sg13_lv_nmos w=1.5u l=0.15u ng=1 m=1
* XOR logic (CMOS style)
XM1 net1 b_bis vdd vdd sg13_lv_pmos w=1.5u l=0.15u ng=1 m=1
XM2 net1 a_in vdd vdd sg13_lv_pmos w=1.5u l=0.15u ng=1 m=1
XM3 out b_in net1 vdd sg13_lv_pmos w=1.5u l=0.15u ng=1 m=1
XM5 net2 a_bis vss vss sg13_lv_nmos w=1.5u l=0.15u ng=1 m=1
XM6 net2 b_bis vss vss sg13_lv_nmos w=1.5u l=0.15u ng=1 m=1
XM7 out b_in net2 vss sg13_lv_nmos w=1.5u l=0.15u ng=1 m=1
* Buffer inverter stage
XM8 b_bis b_in vdd vdd sg13_lv_pmos w=1.5u l=0.15u ng=1 m=1
XM9 out_inv out vdd vdd sg13_lv_pmos w=0.75u l=0.15u ng=1 m=1
XM10 b_bis b_in vss vss sg13_lv_nmos w=1.5u l=0.15u ng=1 m=1
XM11 out_inv out vss vss sg13_lv_nmos w=0.75u l=0.15u ng=1 m=1
.ends xorgate
