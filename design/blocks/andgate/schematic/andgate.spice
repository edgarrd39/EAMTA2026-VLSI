* NGSPICE netlist for andgate - IHP SG13G2 PDK
* Generated from andgate.sch
* Implements AND = NAND + INV

.subckt andgate vdd a_in b_in vss out
* NAND stage
XM0 nand_out a_in vdd vdd sg13_lv_pmos w=2.0u l=0.13u ng=1 m=1
XM1 nand_out b_in vdd vdd sg13_lv_pmos w=2.0u l=0.13u ng=1 m=1
XM2 nand_out a_in nand_mid vss sg13_lv_nmos w=2.0u l=0.13u ng=1 m=1
XM3 nand_mid b_in vss vss sg13_lv_nmos w=2.0u l=0.13u ng=1 m=1
* Inverter output stage
XM4 out nand_out vdd vdd sg13_lv_pmos w=2.0u l=0.13u ng=1 m=1
XM5 out nand_out vss vss sg13_lv_nmos w=1.0u l=0.13u ng=1 m=1
.ends andgate
